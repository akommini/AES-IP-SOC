| / 7\'7
| \ \   Xilinx Inc.
| / /
| \_\/.\   IBIS Models for VIRTEX-6L
[IBIS ver]   3.2
[File name]   watermark_display.ibs
[File Rev]   1.1
|   1.8 - Leveraged from virtex6.ibs v1.8
|   Changed filename and [File name] to "virtex6l.ibs"
|   Removed "G" packages
[Date]   Sun March 03 17:44:31 2013
[Source]   Derived from spice models, mbx40 r0.22, dated 04/30/2009 using
   hspice 2008.03
[Notes]   Xilinx IBIS file for VIRTEX-6L I/O standards.
   All models are preliminary.
   The version of IBISCHK used is ibischk4.
   Ibis models were generated using S2IBIS3.
   C_comp: The C_comp values for the models contained herein have been
   determined, using the procedure suggested in the IBIS Cookbook.
   That is, a 100 mV, 100 MHz sine wave is applied to the pad,
   and the imaginary part of the resulting current is used to
   determine the capacitance "seen" at that node.
   Two groups of typ./min./max. values are provided:
   Input Mode - These values are taken with the driver
   tristated, and are used as the defaults.
   Output Mode - These values are taken with the driver
   enabled, and are included as comments.
   Note) In order to use the Output Mode values, the user must
   comment out the Input Mode values, and uncomment the Output
   Mode values, for the particular standard of interest.
[Disclaimer] The data in this file is derived from SPICE simulations using
                 modeling information extracted from the target process. While
                 a great deal of care has been taken to provide information
                 that is accurate, this model is considered preliminary as it
                 has not been verified by actual silicon measurement. Treat the
                 data in this model as preliminary until actual silicon
                 verification is performed.
[Copyright]   Copyright 2009, Xilinx Inc., All rights reserved
|   Component VIRTEX-6L
[Component]   VIRTEX-6L
[Manufacturer]   Xilinx Inc.
[Package]
|FF1156
|variable   typ   min   max
R_pkg   668.0m   18.0m   1695.0m
L_pkg   5.10nH   0.86nH   11.83nH
C_pkg   2.40pF   0.77pF   4.42pF
[Pin]  signal_name   model_name   R_pin   L_pin   C_pin
F24   watermark<1><4>   LVCMOS25_S_12
R33   binary_data<4>   LVCMOS25_S_12
V27   watermark<7><7>   LVCMOS25_S_12
F23   watermark<1><5>   LVCMOS25_S_12
R34   binary_data<5>   LVCMOS25_S_12
AF25   watermark<8><0>   LVCMOS25_S_12
N23   watermark<1><6>   LVCMOS25_S_12
T30   binary_data<6>   LVCMOS25_S_12
AF24   watermark<8><1>   LVCMOS25_S_12
N24   watermark<1><7>   LVCMOS25_S_12
T31   binary_data<7>   LVCMOS25_S_12
Y24   watermark<8><2>   LVCMOS25_S_12
H25   watermark<2><0>   LVCMOS25_S_12
AA24   watermark<8><3>   LVCMOS25_S_12
H24   watermark<2><1>   LVCMOS25_S_12
AF23   watermark<8><4>   LVCMOS25_S_12
T24   watermark<2><2>   LVCMOS25_S_12
K13   clk   LVCMOS25_S_12
AG23   watermark<8><5>   LVCMOS25_S_12
T23   watermark<2><3>   LVCMOS25_S_12
AA23   watermark<8><6>   LVCMOS25_S_12
AD24   watermark<2><4>   LVCMOS25_S_12
AB23   watermark<8><7>   LVCMOS25_S_12
AE24   watermark<2><5>   LVCMOS25_S_12
V24   watermark<2><6>   LVCMOS25_S_12
W24   watermark<2><7>   LVCMOS25_S_12
W31   watermark<3><0>   LVCMOS25_S_12
W32   watermark<3><1>   LVCMOS25_S_12
Y28   watermark<3><2>   LVCMOS25_S_12
Y27   watermark<3><3>   LVCMOS25_S_12
AC23   watermark<3><4>   LVCMOS25_S_12
AE22   watermark<3><5>   LVCMOS25_S_12
AE23   watermark<3><6>   LVCMOS25_S_12
V25   watermark<3><7>   LVCMOS25_S_12
T33   watermark<4><0>   LVCMOS25_S_12
T34   watermark<4><1>   LVCMOS25_S_12
U26   watermark<4><2>   LVCMOS25_S_12
U27   watermark<4><3>   LVCMOS25_S_12
U33   watermark<4><4>   LVCMOS25_S_12
U32   watermark<4><5>   LVCMOS25_S_12
V30   watermark<4><6>   LVCMOS25_S_12
W30   watermark<4><7>   LVCMOS25_S_12
H23   watermark<5><0>   LVCMOS25_S_12
G23   watermark<5><1>   LVCMOS25_S_12
L23   output_watermark   LVCMOS25_S_12
R24   watermark<5><2>   LVCMOS25_S_12
P24   watermark<5><3>   LVCMOS25_S_12
J25   watermark<5><4>   LVCMOS25_S_12
J24   watermark<5><5>   LVCMOS25_S_12
U23   watermark<5><6>   LVCMOS25_S_12
V23   watermark<5><7>   LVCMOS25_S_12
V32   watermark<6><0>   LVCMOS25_S_12
V33   watermark<6><1>   LVCMOS25_S_12
Y32   watermark<6><2>   LVCMOS25_S_12
Y31   watermark<6><3>   LVCMOS25_S_12
Y33   watermark<6><4>   LVCMOS25_S_12
Y34   watermark<6><5>   LVCMOS25_S_12
W29   watermark<6><6>   LVCMOS25_S_12
Y29   watermark<6><7>   LVCMOS25_S_12
U31   watermark<7><0>   LVCMOS25_S_12
V28   watermark<7><1>   LVCMOS25_S_12
U28   watermark<7><2>   LVCMOS25_S_12
K24   watermark<1><0>   LVCMOS25_S_12
U25   binary_data<0>   LVCMOS25_S_12
V29   watermark<7><3>   LVCMOS25_S_12
K23   watermark<1><1>   LVCMOS25_S_12
M22   binary_data<1>   LVCMOS25_S_12
T25   rst   LVCMOS25_S_12
V34   watermark<7><4>   LVCMOS25_S_12
M23   watermark<1><2>   LVCMOS25_S_12
T28   binary_data<2>   LVCMOS25_S_12
W34   watermark<7><5>   LVCMOS25_S_12
L24   watermark<1><3>   LVCMOS25_S_12
T29   binary_data<3>   LVCMOS25_S_12
U30   watermark<7><6>   LVCMOS25_S_12
U18   VP_0   NC
V17   VN_0   NC
AD25   IO_L0P_12   NC
AD26   IO_L0N_12   NC
AE27   IO_L1P_12   NC
AD27   IO_L1N_12   NC
AH33   IO_L2P_12   NC
AH32   IO_L2N_12   NC
AE28   IO_L3P_12   NC
AE29   IO_L3N_12   NC
AJ34   IO_L4P_12   NC
AH34   IO_L4N_VREF_12   NC
AF28   IO_L5P_12   NC
AF29   IO_L5N_12   NC
AL34   IO_L6P_12   NC
AK34   IO_L6N_12   NC
AH29   IO_L7P_12   NC
AH30   IO_L7N_12   NC
AN33   SRCC   LVCMOS25_F_12
AN34   SRCC   LVCMOS25_F_12
AG27   MRCC   LVCMOS25_F_12
AG28   MRCC   LVCMOS25_F_12
AF30   MRCC   LVCMOS25_F_12
AG30   MRCC   LVCMOS25_F_12
AF26   SRCC   LVCMOS25_F_12
AE26   SRCC   LVCMOS25_F_12
AJ31   IO_L12P_VRN_12   NC
AJ32   IO_L12N_VRP_12   NC
AJ29   IO_L13P_12   NC
AJ30   IO_L13N_12   NC
AK33   IO_L14P_12   NC
AK32   IO_L14N_VREF_12   NC
AL31   IO_L15P_12   NC
AK31   IO_L15N_12   NC
AM33   IO_L16P_12   NC
AL33   IO_L16N_12   NC
AN32   IO_L17P_12   NC
AM32   IO_L17N_12   NC
AP32   IO_L18P_12   NC
AP33   IO_L18N_12   NC
AL30   IO_L19P_12   NC
AM31   IO_L19N_12   NC
AA34   IO_L0P_13   NC
AA33   IO_L0N_13   NC
AA30   IO_L1P_13   NC
AA31   IO_L1N_13   NC
AD34   IO_L2P_13   NC
AC34   IO_L2N_13   NC
AB30   IO_L3P_13   NC
AB31   IO_L3N_13   NC
AC33   IO_L4P_13   NC
AB33   IO_L4N_VREF_13   NC
AE31   IO_L5P_13   NC
AD31   IO_L5N_13   NC
AA25   IO_L6P_13   NC
Y26   IO_L6N_13   NC
AA28   IO_L7P_13   NC
AA29   IO_L7N_13   NC
AE34   SRCC   LVCMOS25_F_12
AF34   SRCC   LVCMOS25_F_12
AD30   MRCC   LVCMOS25_F_12
AC30   MRCC   LVCMOS25_F_12
AE33   MRCC   LVCMOS25_F_12
AF33   MRCC   LVCMOS25_F_12
AD29   SRCC   LVCMOS25_F_12
AC29   SRCC   LVCMOS25_F_12
AB32   IO_L12P_VRN_13   NC
AC32   IO_L12N_VRP_13   NC
AB28   IO_L13P_13   NC
AC28   IO_L13N_13   NC
AD32   IO_L14P_13   NC
AE32   IO_L14N_VREF_13   NC
AB27   IO_L15P_13   NC
AC27   IO_L15N_13   NC
AG33   IO_L16P_13   NC
AG32   IO_L16N_13   NC
AA26   IO_L17P_13   NC
AB26   IO_L17N_13   NC
AG31   IO_L18P_13   NC
AF31   IO_L18N_13   NC
AB25   IO_L19P_13   NC
AC25   IO_L19N_13   NC
W25   IO_L18P_14   NC
W27   IO_L19P_14   NC
W26   IO_L19N_14   NC
M31   IO_L0P_15   NC
L31   IO_L0N_15   NC
N25   IO_L1P_15   NC
M25   IO_L1N_15   NC
K32   SM8P   NC
K31   SM8N   NC
M26   SM9P   NC
M27   SM9N   NC
P31   IO_L4P_15   NC
P30   IO_L4N_VREF_15   NC
N27   SM10P   NC
P27   SM10N   NC
L33   SM11P   NC
M32   SM11N   NC
L28   SM12P   NC
M28   SM12N   NC
N32   SRCC   LVCMOS25_F_12
P32   SRCC   LVCMOS25_F_12
N28   MRCC   LVCMOS25_F_12
N29   MRCC   LVCMOS25_F_12
N33   MRCC   LVCMOS25_F_12
M33   MRCC   LVCMOS25_F_12
L29   SRCC   LVCMOS25_F_12
L30   SRCC   LVCMOS25_F_12
P25   SM13P   NC
P26   SM13N   NC
R28   SM14P   NC
R27   SM14N   NC
R31   IO_L14P_15   NC
R32   IO_L14N_VREF_15   NC
R26   SM15P   NC
T26   SM15N   NC
K34   IO_L16P_VRN_15   NC
L34   IO_L16N_VRP_15   NC
M30   IO_L17P_15   NC
N30   IO_L17N_15   NC
N34   IO_L18P_15   NC
P34   IO_L18N_15   NC
P29   IO_L19P_15   NC
R29   IO_L19N_15   NC
C32   IO_L0P_16   NC
B32   IO_L0N_16   NC
J26   IO_L1P_16   NC
J27   IO_L1N_16   NC
E32   IO_L2P_16   NC
E33   IO_L2N_16   NC
F30   IO_L3P_16   NC
G30   IO_L3N_16   NC
A33   IO_L4P_16   NC
B33   IO_L4N_VREF_16   NC
G31   IO_L5P_16   NC
H30   IO_L5N_16   NC
C33   IO_L6P_16   NC
B34   IO_L6N_16   NC
K28   IO_L7P_16   NC
J29   IO_L7N_16   NC
D34   SRCC   LVCMOS25_F_12
C34   SRCC   LVCMOS25_F_12
K26   MRCC   LVCMOS25_F_12
K27   MRCC   LVCMOS25_F_12
F33   MRCC   LVCMOS25_F_12
G33   MRCC   LVCMOS25_F_12
F31   SRCC   LVCMOS25_F_12
E31   SRCC   LVCMOS25_F_12
E34   IO_L12P_VRN_16   NC
F34   IO_L12N_VRP_16   NC
J30   IO_L13P_16   NC
K29   IO_L13N_16   NC
H34   IO_L14P_16   NC
H33   IO_L14N_VREF_16   NC
D31   IO_L15P_16   NC
D32   IO_L15N_16   NC
K33   IO_L16P_16   NC
J34   IO_L16N_16   NC
G32   IO_L17P_16   NC
H32   IO_L17N_16   NC
L25   IO_L18P_16   NC
L26   IO_L18N_16   NC
J31   IO_L19P_16   NC
J32   IO_L19N_16   NC
AE21   IO_L0P_22   NC
AD21   IO_L0N_22   NC
AM18   IO_L1P_22   NC
AL18   IO_L1N_22   NC
AG22   IO_L2P_22   NC
AH22   IO_L2N_22   NC
AP19   IO_L3P_22   NC
AN18   IO_L3N_22   NC
AK22   IO_L4P_22   NC
AJ22   IO_L4N_VREF_22   NC
AN19   IO_L5P_22   NC
AN20   IO_L5N_22   NC
AC20   IO_L6P_22   NC
AD20   IO_L6N_22   NC
AM20   IO_L7P_22   NC
AL20   IO_L7N_22   NC
AF19   SRCC   LVCMOS25_F_12
AE19   SRCC   LVCMOS25_F_12
AP20   MRCC   LVCMOS25_F_12
AP21   MRCC   LVCMOS25_F_12
AK19   MRCC   LVCMOS25_F_12
AL19   MRCC   LVCMOS25_F_12
AF20   SRCC   LVCMOS25_F_12
AF21   SRCC   LVCMOS25_F_12
AJ20   IO_L12P_VRN_22   NC
AH20   IO_L12N_VRP_22   NC
AM21   IO_L13P_22   NC
AL21   IO_L13N_22   NC
AC19   IO_L14P_22   NC
AD19   IO_L14N_VREF_22   NC
AM23   IO_L15P_22   NC
AL23   IO_L15N_22   NC
AK21   IO_L16P_22   NC
AJ21   IO_L16N_22   NC
AM22   IO_L17P_22   NC
AN22   IO_L17N_22   NC
AG20   IO_L18P_22   NC
AG21   IO_L18N_22   NC
AP22   IO_L19P_22   NC
AN23   IO_L19N_22   NC
AH27   IO_L0P_23   NC
AH28   IO_L0N_23   NC
AN30   IO_L1P_23   NC
AM30   IO_L1N_23   NC
AG25   IO_L2P_23   NC
AG26   IO_L2N_23   NC
AP30   IO_L3P_23   NC
AP31   IO_L3N_23   NC
AL29   IO_L4P_23   NC
AK29   IO_L4N_VREF_23   NC
AN29   IO_L5P_23   NC
AP29   IO_L5N_23   NC
AL28   IO_L6P_23   NC
AK28   IO_L6N_23   NC
AN28   IO_L7P_23   NC
AM28   IO_L7N_23   NC
AH25   SRCC   LVCMOS25_F_12
AJ25   SRCC   LVCMOS25_F_12
AN27   MRCC   LVCMOS25_F_12
AM27   MRCC   LVCMOS25_F_12
AK27   MRCC   LVCMOS25_F_12
AJ27   MRCC   LVCMOS25_F_12
AH23   SRCC   LVCMOS25_F_12
AH24   SRCC   LVCMOS25_F_12
AK26   IO_L12P_VRN_23   NC
AJ26   IO_L12N_VRP_23   NC
AL26   IO_L13P_23   NC
AM26   IO_L13N_23   NC
AJ24   IO_L14P_23   NC
AK24   IO_L14N_VREF_23   NC
AP27   IO_L15P_23   NC
AP26   IO_L15N_23   NC
AM25   IO_L16P_23   NC
AL25   IO_L16N_23   NC
AN25   IO_L17P_23   NC
AN24   IO_L17N_23   NC
AK23   IO_L18P_23   NC
AL24   IO_L18N_23   NC
AP25   IO_L19P_23   NC
AP24   IO_L19N_23   NC
AC24   IO_L18N_24   NC
AC22   IO_L19P_24   NC
AD22   IO_L19N_24   NC
D25   IO_L0P_25   NC
D26   IO_L0N_25   NC
C24   IO_L1P_25   NC
C25   IO_L1N_25   NC
E26   IO_L2P_25   NC
F26   IO_L2N_25   NC
B25   IO_L3P_25   NC
A25   IO_L3N_25   NC
D27   IO_L4P_25   NC
E27   IO_L4N_VREF_25   NC
B26   IO_L5P_25   NC
A26   IO_L5N_25   NC
G26   IO_L6P_25   NC
G27   IO_L6N_25   NC
B27   IO_L7P_25   NC
C27   IO_L7N_25   NC
D24   SRCC   LVCMOS25_F_12
E24   SRCC   LVCMOS25_F_12
C28   MRCC   LVCMOS25_F_12
B28   MRCC   LVCMOS25_F_12
C29   MRCC   LVCMOS25_F_12
D29   MRCC   LVCMOS25_F_12
F25   SRCC   LVCMOS25_F_12
G25   SRCC   LVCMOS25_F_12
H27   IO_L12P_25   NC
G28   IO_L12N_25   NC
A28   IO_L13P_25   NC
A29   IO_L13N_25   NC
F28   IO_L14P_25   NC
E28   IO_L14N_VREF_25   NC
A30   IO_L15P_25   NC
B30   IO_L15N_25   NC
E29   IO_L16P_VRN_25   NC
F29   IO_L16N_VRP_25   NC
C30   IO_L17P_25   NC
D30   IO_L17N_25   NC
H28   IO_L18P_GC_25   NC
H29   IO_L18N_GC_25   NC
B31   IO_L19P_GC_25   NC
A31   IO_L19N_GC_25   NC
C20   IO_L0P_26   NC
D20   IO_L0N_26   NC
A23   IO_L1P_26   NC
A24   IO_L1N_26   NC
G21   IO_L2P_26   NC
G22   IO_L2N_26   NC
B23   IO_L3P_26   NC
C23   IO_L3N_26   NC
J20   IO_L4P_26   NC
J21   IO_L4N_VREF_26   NC
B21   IO_L5P_26   NC
B22   IO_L5N_26   NC
E22   IO_L6P_26   NC
E23   IO_L6N_26   NC
A20   IO_L7P_26   NC
A21   IO_L7N_26   NC
F19   SRCC   LVCMOS25_F_12
F20   SRCC   LVCMOS25_F_12
B20   MRCC   LVCMOS25_F_12
C19   MRCC   LVCMOS25_F_12
F21   MRCC   LVCMOS25_F_12
G20   MRCC   LVCMOS25_F_12
H19   SRCC   LVCMOS25_F_12
H20   SRCC   LVCMOS25_F_12
D21   IO_L12P_VRN_26   NC
E21   IO_L12N_VRP_26   NC
E19   IO_L13P_26   NC
D19   IO_L13N_26   NC
H22   IO_L14P_26   NC
J22   IO_L14N_VREF_26   NC
A18   IO_L15P_26   NC
A19   IO_L15N_26   NC
K21   IO_L16P_26   NC
K22   IO_L16N_26   NC
B18   IO_L17P_26   NC
C18   IO_L17N_26   NC
L20   IO_L18P_26   NC
L21   IO_L18N_26   NC
C22   IO_L19P_26   NC
D22   IO_L19N_26   NC
AG15   IO_L0P_32   NC
AF15   IO_L0N_32   NC
AK14   IO_L1P_32   NC
AJ14   IO_L1N_32   NC
AJ15   IO_L2P_32   NC
AH15   IO_L2N_32   NC
AL15   IO_L3P_32   NC
AL14   IO_L3N_32   NC
AG16   IO_L4P_32   NC
AF16   IO_L4N_VREF_32   NC
AN15   IO_L5P_32   NC
AM15   IO_L5N_32   NC
AJ17   IO_L6P_32   NC
AJ16   IO_L6N_32   NC
AP16   IO_L7P_32   NC
AP15   IO_L7N_32   NC
AH17   SRCC   LVCMOS25_F_12
AG17   SRCC   LVCMOS25_F_12
AC15   MRCC   LVCMOS25_F_12
AD15   MRCC   LVCMOS25_F_12
AE16   MRCC   LVCMOS25_F_12
AD16   MRCC   LVCMOS25_F_12
AC18   SRCC   LVCMOS25_F_12
AC17   SRCC   LVCMOS25_F_12
AH18   IO_L12P_VRN_32   NC
AG18   IO_L12N_VRP_32   NC
AN17   IO_L13P_32   NC
AP17   IO_L13N_32   NC
AJ19   IO_L14P_32   NC
AH19   IO_L14N_VREF_32   NC
AM17   IO_L15P_32   NC
AM16   IO_L15N_32   NC
AD17   IO_L16P_32   NC
AE17   IO_L16N_32   NC
AK18   IO_L17P_32   NC
AK17   IO_L17N_32   NC
AE18   IO_L18P_32   NC
AF18   IO_L18N_32   NC
AL16   IO_L19P_32   NC
AK16   IO_L19N_32   NC
AE13   IO_L0P_33   NC
AE12   IO_L0N_33   NC
AJ11   IO_L1P_33   NC
AK11   IO_L1N_33   NC
AD14   IO_L2P_33   NC
AC14   IO_L2N_33   NC
AK12   IO_L3P_33   NC
AJ12   IO_L3N_33   NC
AF11   IO_L4P_33   NC
AE11   IO_L4N_VREF_33   NC
AM10   IO_L5P_33   NC
AL10   IO_L5N_33   NC
AG11   IO_L6P_33   NC
AG10   IO_L6N_33   NC
AL11   IO_L7P_33   NC
AM11   IO_L7N_33   NC
AJ10   SRCC   LVCMOS25_F_12
AH10   SRCC   LVCMOS25_F_12
AC13   MRCC   LVCMOS25_F_12
AC12   MRCC   LVCMOS25_F_12
AD12   MRCC   LVCMOS25_F_12
AD11   MRCC   LVCMOS25_F_12
AP11   SRCC   LVCMOS25_F_12
AP12   SRCC   LVCMOS25_F_12
AF13   IO_L12P_VRN_33   NC
AG13   IO_L12N_VRP_33   NC
AM12   IO_L13P_33   NC
AN12   IO_L13N_33   NC
AE14   IO_L14P_33   NC
AF14   IO_L14N_VREF_33   NC
AN13   IO_L15P_33   NC
AM13   IO_L15N_33   NC
AG12   IO_L16P_33   NC
AH12   IO_L16N_33   NC
AK13   IO_L17P_33   NC
AL13   IO_L17N_33   NC
AH13   IO_L18P_33   NC
AH14   IO_L18N_33   NC
AP14   IO_L19P_33   NC
AN14   IO_L19N_33   NC
J9   IO_L0P_GC_34   NC
H9   IO_L0N_GC_34   NC
A10   IO_L1P_GC_34   NC
B10   IO_L1N_GC_34   NC
F9   A15_D31   NC
F10   A14_D30   NC
C10   A13_D29   NC
D10   A12_D28   NC
C9   A11_D27   NC
D9   A10_D26   NC
A9   A09_D25   NC
A8   A08_D24   NC
E8   A07_D23   NC
E9   A06_D22   NC
B8   A05_D21   NC
C8   A04_D20   NC
L9   SRCC   LVCMOS25_F_12
K9   SRCC   LVCMOS25_F_12
L10   MRCC   LVCMOS25_F_12
M10   MRCC   LVCMOS25_F_12
AC10   MRCC   LVCMOS25_F_12
AB10   MRCC   LVCMOS25_F_12
AH9   SRCC   LVCMOS25_F_12
AJ9   SRCC   LVCMOS25_F_12
AD10   A03_D19   NC
AC9   A02_D18   NC
AK8   A01_D17   NC
AL8   A00_D16   NC
AD9   A25   LVCMOS25_F_12
AE9   A24   LVCMOS25_F_12
AK9   A23   LVCMOS25_F_12
AL9   A22   LVCMOS25_F_12
AF9   A21   LVCMOS25_F_12
AF10   A20   LVCMOS25_F_12
AN9   A19   LVCMOS25_F_12
AP9   A18   LVCMOS25_F_12
AG8   A17   LVCMOS25_F_12
AH8   A16   LVCMOS25_F_12
AN10   IO_L19P_VRN_34   NC
AP10   IO_L19N_VRP_34   NC
G13   IO_L0P_35   NC
H14   IO_L0N_35   NC
D14   IO_L1P_35   NC
C14   IO_L1N_35   NC
G11   SM0P   LVCMOS25_F_12
F11   SM0N   LVCMOS25_F_12
A13   SM1P   LVCMOS25_F_12
A14   SM1N   LVCMOS25_F_12
G12   IO_L4P_35   NC
H13   IO_L4N_VREF_35   NC
F14   SM2P   LVCMOS25_F_12
E14   SM2N   LVCMOS25_F_12
H10   SM3P   LVCMOS25_F_12
G10   SM3N   LVCMOS25_F_12
B12   SM4P   LVCMOS25_F_12
B13   SM4N   LVCMOS25_F_12
K14   SRCC   LVCMOS25_F_12
J14   SRCC   LVCMOS25_F_12
L13   MRCC   LVCMOS25_F_12
M13   MRCC   LVCMOS25_F_12
M12   MRCC   LVCMOS25_F_12
M11   MRCC   LVCMOS25_F_12
C13   SRCC   LVCMOS25_F_12
C12   SRCC   LVCMOS25_F_12
H12   SM5P   LVCMOS25_F_12
J12   SM5N   LVCMOS25_F_12
A11   SM6P   LVCMOS25_F_12
B11   SM6N   LVCMOS25_F_12
J11   IO_L14P_35   NC
J10   IO_L14N_VREF_35   NC
E13   SM7P   LVCMOS25_F_12
F13   SM7N   LVCMOS25_F_12
K11   IO_L16P_VRN_35   NC
L11   IO_L16N_VRP_35   NC
D12   IO_L17P_35   NC
E12   IO_L17N_35   NC
K12   IO_L18N_GC_35   NC
D11   IO_L19P_GC_35   NC
E11   IO_L19N_GC_35   NC
F18   IO_L0P_36   NC
E17   IO_L0N_36   NC
E18   IO_L1P_36   NC
D17   IO_L1N_36   NC
K18   IO_L2P_36   NC
K17   IO_L2N_36   NC
H17   IO_L3P_36   NC
G17   IO_L3N_36   NC
L19   IO_L4P_36   NC
L18   IO_L4N_VREF_36   NC
C17   IO_L5P_36   NC
B17   IO_L5N_36   NC
K19   IO_L6P_36   NC
J19   IO_L6N_36   NC
M18   IO_L7P_36   NC
M17   IO_L7N_36   NC
G18   SRCC   LVCMOS25_F_12
H18   SRCC   LVCMOS25_F_12
K16   MRCC   LVCMOS25_F_12
L16   MRCC   LVCMOS25_F_12
L15   MRCC   LVCMOS25_F_12
L14   MRCC   LVCMOS25_F_12
A16   SRCC   LVCMOS25_F_12
B16   SRCC   LVCMOS25_F_12
F16   IO_L12P_VRN_36   NC
G16   IO_L12N_VRP_36   NC
E16   IO_L13P_36   NC
D16   IO_L13N_36   NC
J17   IO_L14P_36   NC
J16   IO_L14N_VREF_36   NC
A15   IO_L15P_36   NC
B15   IO_L15N_36   NC
G15   IO_L16P_36   NC
F15   IO_L16N_36   NC
M16   IO_L17P_36   NC
M15   IO_L17N_36   NC
H15   IO_L18P_36   NC
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[Package Model]   ff1156_xc6vlx130tl
[Diff Pin]   inv_pin   vdiff   tdelay_typ   tdelay_min   tdelay_max
[Series Pin Mapping] pin_2   model_name   function_table_group
[Define Package Model]   ff1156_xc6vlx130tl
[Manufacturer]   Xilinx Inc.
[OEM]   Xilinx_K1
[Description]   1156 ball organic flip-chip
|[Number of Sections]   1
[Number of Pins]   750
[Pin Numbers]
|[Pin Name]  Net Number   Net Name   Net's All Pins
T18   | 1   AVDD_0   T18
T17   | 2   AVSS_0   T17
C6   | 3   MGTAVCC_N   C6
   |E6
   |G6
   |J6
   |L6
   |N6
AA6   | 4   MGTAVCC_S   AA6
   |AC6
   |AE6
   |AG6
   |AJ6
   |AL6
   |AN6
   |R6
   |U6
   |W6
AP7   | 5   MGTAVTTRCAL_115   AP7
C2   | 6   MGTAVTT_N   C2
   |D3
   |G2
   |H3
   |L2
   |M3
AC2   | 7   MGTAVTT_S   AC2
   |AD3
   |AG2
   |AH3
   |AL2
   |AM3
   |R2
   |T3
   |W2
   |Y3
AA10   | 8   VCCAUX   AA10
   |AA22
   |N10
   |N22
   |P23
   |P9
   |R22
   |T9
   |U22
   |V9
   |W10
   |W22
   |Y23
AA12   | 9   VCCINT   AA12
   |AA14
   |AA16
   |AA18
   |AA20
   |AB11
   |AB13
   |AB15
   |AB17
   |AB19
   |AB21
   |M19
   |M21
   |N12
   |N14
   |N16
   |N18
   |N20
   |P11
   |P13
   |P15
   |P17
   |P19
   |P21
   |R10
   |R12
   |R14
   |R16
   |R18
   |R20
   |T11
   |T13
   |T15
   |T19
   |T21
   |U10
   |U12
   |U14
   |U16
   |U20
   |V11
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AB9   | 10   VCCO_0   AB9
   |Y9
AF27   | 11   VCCO_12   AF27
   |AG34
   |AH31
   |AL32
AA32   | 12   VCCO_13   AA32
   |AB29
   |AC26
   |AD33
   |AE30
T27   | 13   VCCO_14   T27
   |U34
   |V31
   |W28
L32   | 14   VCCO_15   L32
   |M29
   |N26
   |P33
   |R30
A32   | 15   VCCO_16   A32
   |D33
   |G34
   |H31
   |J28
   |K25
AE20   | 16   VCCO_22   AE20
   |AH21
   |AL22
   |AM19
   |AP23
AJ28   | 17   VCCO_23   AJ28
   |AK25
   |AM29
   |AN26
AD23   | 18   VCCO_24   AD23
   |AG24
   |G24
   |L22
   |U24
   |Y25
B29   | 19   VCCO_25   B29
   |C26
   |E30
   |F27
A22   | 20   VCCO_26   A22
   |B19
   |D23
   |E20
   |H21
AC16   | 21   VCCO_32   AC16
   |AF17
   |AJ18
   |AK15
   |AN16
AD13   | 22   VCCO_33   AD13
   |AG14
   |AH11
   |AL12
   |AP13
AE10   | 23   VCCO_34   AE10
   |AJ8
   |AM9
   |B9
   |E10
   |M9
A12   | 24   VCCO_35   A12
   |D13
   |G14
   |H11
   |L12
C16   | 25   VCCO_36   C16
   |F17
   |J18
   |K15
K8   | 26   CCLK_0   K8
F8   | 27   CSI_B_0   F8
H8   | 28   DIN_0   H8
R8   | 29   DONE_0   R8
AA8   | 30   DOUT_BUSY_0   AA8
W17   | 31   DXN_0   W17
W18   | 32   DXP_0   W18
M8   | 33   HSWAPEN_0   M8
P8   | 34   INIT_B_0   P8
AD26   | 35   IO_L0N_12   AD26
AA33   | 36   IO_L0N_13   AA33
T25   | 37   IO_L0N_14   T25
L31   | 38   IO_L0N_15   L31
B32   | 39   IO_L0N_16   B32
AD21   | 40   IO_L0N_22   AD21
AH28   | 41   IO_L0N_23   AH28
D26   | 42   IO_L0N_25   D26
D20   | 43   IO_L0N_26   D20
AF15   | 44   IO_L0N_32   AF15
AE12   | 45   IO_L0N_33   AE12
H14   | 46   IO_L0N_35   H14
E17   | 47   IO_L0N_36   E17
M22   | 48   IO_L0N_GC_24   M22
H9   | 49   IO_L0N_GC_34   H9
AD25   | 50   IO_L0P_12   AD25
AA34   | 51   IO_L0P_13   AA34
U25   | 52   IO_L0P_14   U25
M31   | 53   IO_L0P_15   M31
C32   | 54   IO_L0P_16   C32
AE21   | 55   IO_L0P_22   AE21
AH27   | 56   IO_L0P_23   AH27
D25   | 57   IO_L0P_25   D25
C20   | 58   IO_L0P_26   C20
AG15   | 59   IO_L0P_32   AG15
AE13   | 60   IO_L0P_33   AE13
G13   | 61   IO_L0P_35   G13
F18   | 62   IO_L0P_36   F18
L23   | 63   IO_L0P_GC_24   L23
J9   | 64   IO_L0P_GC_34   J9
AG30   | 65   IO_L10N_MRCC_12   AG30
AF33   | 66   IO_L10N_MRCC_13   AF33
W34   | 67   IO_L10N_MRCC_14   W34
M33   | 68   IO_L10N_MRCC_15   M33
G33   | 69   IO_L10N_MRCC_16   G33
AL19   | 70   IO_L10N_MRCC_22   AL19
AJ27   | 71   IO_L10N_MRCC_23   AJ27
V23   | 72   IO_L10N_MRCC_24   V23
D29   | 73   IO_L10N_MRCC_25   D29
G20   | 74   IO_L10N_MRCC_26   G20
AD16   | 75   IO_L10N_MRCC_32   AD16
AD11   | 76   IO_L10N_MRCC_33   AD11
AB10   | 77   IO_L10N_MRCC_34   AB10
M11   | 78   IO_L10N_MRCC_35   M11
L14   | 79   IO_L10N_MRCC_36   L14
AF30   | 80   IO_L10P_MRCC_12   AF30
AE33   | 81   IO_L10P_MRCC_13   AE33
V34   | 82   IO_L10P_MRCC_14   V34
N33   | 83   IO_L10P_MRCC_15   N33
F33   | 84   IO_L10P_MRCC_16   F33
AK19   | 85   IO_L10P_MRCC_22   AK19
AK27   | 86   IO_L10P_MRCC_23   AK27
U23   | 87   IO_L10P_MRCC_24   U23
C29   | 88   IO_L10P_MRCC_25   C29
F21   | 89   IO_L10P_MRCC_26   F21
AE16   | 90   IO_L10P_MRCC_32   AE16
AD12   | 91   IO_L10P_MRCC_33   AD12
AC10   | 92   IO_L10P_MRCC_34   AC10
M12   | 93   IO_L10P_MRCC_35   M12
L15   | 94   IO_L10P_MRCC_36   L15
AE26   | 95   IO_L11N_SRCC_12   AE26
AC29   | 96   IO_L11N_SRCC_13   AC29
V27   | 97   IO_L11N_SRCC_14   V27
L30   | 98   IO_L11N_SRCC_15   L30
E31   | 99   IO_L11N_SRCC_16   E31
AF21   | 100   IO_L11N_SRCC_22   AF21
AH24   | 101   IO_L11N_SRCC_23   AH24
AE24   | 102   IO_L11N_SRCC_24   AE24
G25   | 103   IO_L11N_SRCC_25   G25
H20   | 104   IO_L11N_SRCC_26   H20
AC17   | 105   IO_L11N_SRCC_32   AC17
AP12   | 106   IO_L11N_SRCC_33   AP12
AJ9   | 107   IO_L11N_SRCC_34   AJ9
C12   | 108   IO_L11N_SRCC_35   C12
B16   | 109   IO_L11N_SRCC_36   B16
AF26   | 110   IO_L11P_SRCC_12   AF26
AD29   | 111   IO_L11P_SRCC_13   AD29
V28   | 112   IO_L11P_SRCC_14   V28
L29   | 113   IO_L11P_SRCC_15   L29
F31   | 114   IO_L11P_SRCC_16   F31
AF20   | 115   IO_L11P_SRCC_22   AF20
AH23   | 116   IO_L11P_SRCC_23   AH23
AD24   | 117   IO_L11P_SRCC_24   AD24
F25   | 118   IO_L11P_SRCC_25   F25
H19   | 119   IO_L11P_SRCC_26   H19
AC18   | 120   IO_L11P_SRCC_32   AC18
AP11   | 121   IO_L11P_SRCC_33   AP11
AH9   | 122   IO_L11P_SRCC_34   AH9
C13   | 123   IO_L11P_SRCC_35   C13
A16   | 124   IO_L11P_SRCC_36   A16
G28   | 125   IO_L12N_25   G28
AC9   | 126   IO_L12N_A02_D18_34   AC9
W24   | 127   IO_L12N_D2_FS2_24   W24
P26   | 128   IO_L12N_SM13N_15   P26
J12   | 129   IO_L12N_SM5N_35   J12
AJ32   | 130   IO_L12N_VRP_12   AJ32
AC32   | 131   IO_L12N_VRP_13   AC32
V33   | 132   IO_L12N_VRP_14   V33
F34   | 133   IO_L12N_VRP_16   F34
AH20   | 134   IO_L12N_VRP_22   AH20
AJ26   | 135   IO_L12N_VRP_23   AJ26
E21   | 136   IO_L12N_VRP_26   E21
AG18   | 137   IO_L12N_VRP_32   AG18
AG13   | 138   IO_L12N_VRP_33   AG13
G16   | 139   IO_L12N_VRP_36   G16
H27   | 140   IO_L12P_25   H27
AD10   | 141   IO_L12P_A03_D19_34   AD10
V24   | 142   IO_L12P_D3_24   V24
P25   | 143   IO_L12P_SM13P_15   P25
H12   | 144   IO_L12P_SM5P_35   H12
AJ31   | 145   IO_L12P_VRN_12   AJ31
AB32   | 146   IO_L12P_VRN_13   AB32
V32   | 147   IO_L12P_VRN_14   V32
E34   | 148   IO_L12P_VRN_16   E34
AJ20   | 149   IO_L12P_VRN_22   AJ20
AK26   | 150   IO_L12P_VRN_23   AK26
D21   | 151   IO_L12P_VRN_26   D21
AH18   | 152   IO_L12P_VRN_32   AH18
AF13   | 153   IO_L12P_VRN_33   AF13
F16   | 154   IO_L12P_VRN_36   F16
AJ30   | 155   IO_L13N_12   AJ30
AC28   | 156   IO_L13N_13   AC28
Y31   | 157   IO_L13N_14   Y31
K29   | 158   IO_L13N_16   K29
AL21   | 159   IO_L13N_22   AL21
AM26   | 160   IO_L13N_23   AM26
A29   | 161   IO_L13N_25   A29
D19   | 162   IO_L13N_26   D19
AP17   | 163   IO_L13N_32   AP17
AN12   | 164   IO_L13N_33   AN12
D16   | 165   IO_L13N_36   D16
AL8   | 166   IO_L13N_A00_D16_34   AL8
AF24   | 167   IO_L13N_D0_FS0_24   AF24
R27   | 168   IO_L13N_SM14N_15   R27
B11   | 169   IO_L13N_SM6N_35   B11
AJ29   | 170   IO_L13P_12   AJ29
AB28   | 171   IO_L13P_13   AB28
Y32   | 172   IO_L13P_14   Y32
J30   | 173   IO_L13P_16   J30
AM21   | 174   IO_L13P_22   AM21
AL26   | 175   IO_L13P_23   AL26
A28   | 176   IO_L13P_25   A28
E19   | 177   IO_L13P_26   E19
AN17   | 178   IO_L13P_32   AN17
AM12   | 179   IO_L13P_33   AM12
E16   | 180   IO_L13P_36   E16
AK8   | 181   IO_L13P_A01_D17_34   AK8
AF25   | 182   IO_L13P_D1_FS1_24   AF25
R28   | 183   IO_L13P_SM14P_15   R28
A11   | 184   IO_L13P_SM6P_35   A11
AK32   | 185   IO_L14N_VREF_12   AK32
AE32   | 186   IO_L14N_VREF_13   AE32
Y34   | 187   IO_L14N_VREF_14   Y34
R32   | 188   IO_L14N_VREF_15   R32
H33   | 189   IO_L14N_VREF_16   H33
AD19   | 190   IO_L14N_VREF_22   AD19
AK24   | 191   IO_L14N_VREF_23   AK24
E28   | 192   IO_L14N_VREF_25   E28
J22   | 193   IO_L14N_VREF_26   J22
AH19   | 194   IO_L14N_VREF_32   AH19
AF14   | 195   IO_L14N_VREF_33   AF14
J10   | 196   IO_L14N_VREF_35   J10
J16   | 197   IO_L14N_VREF_36   J16
AE9   | 198   IO_L14N_VREF_A24_34   AE9
AA24   | 199   IO_L14N_VREF_FOE_B_MOSI_24   AA24
AK33   | 200   IO_L14P_12   AK33
AD32   | 201   IO_L14P_13   AD32
Y33   | 202   IO_L14P_14   Y33
R31   | 203   IO_L14P_15   R31
H34   | 204   IO_L14P_16   H34
AC19   | 205   IO_L14P_22   AC19
AJ24   | 206   IO_L14P_23   AJ24
F28   | 207   IO_L14P_25   F28
H22   | 208   IO_L14P_26   H22
AJ19   | 209   IO_L14P_32   AJ19
AE14   | 210   IO_L14P_33   AE14
J11   | 211   IO_L14P_35   J11
J17   | 212   IO_L14P_36   J17
AD9   | 213   IO_L14P_A25_34   AD9
Y24   | 214   IO_L14P_FCS_B_24   Y24
AK31   | 215   IO_L15N_12   AK31
AC27   | 216   IO_L15N_13   AC27
Y29   | 217   IO_L15N_14   Y29
D32   | 218   IO_L15N_16   D32
AL23   | 219   IO_L15N_22   AL23
AP26   | 220   IO_L15N_23   AP26
B30   | 221   IO_L15N_25   B30
A19   | 222   IO_L15N_26   A19
AM16   | 223   IO_L15N_32   AM16
AM13   | 224   IO_L15N_33   AM13
B15   | 225   IO_L15N_36   B15
AL9   | 226   IO_L15N_A22_34   AL9
AG23   | 227   IO_L15N_RS1_24   AG23
T26   | 228   IO_L15N_SM15N_15   T26
F13   | 229   IO_L15N_SM7N_35   F13
AL31   | 230   IO_L15P_12   AL31
AB27   | 231   IO_L15P_13   AB27
W29   | 232   IO_L15P_14   W29
D31   | 233   IO_L15P_16   D31
AM23   | 234   IO_L15P_22   AM23
AP27   | 235   IO_L15P_23   AP27
A30   | 236   IO_L15P_25   A30
A18   | 237   IO_L15P_26   A18
AM17   | 238   IO_L15P_32   AM17
AN13   | 239   IO_L15P_33   AN13
A15   | 240   IO_L15P_36   A15
AK9   | 241   IO_L15P_A23_34   AK9
AF23   | 242   IO_L15P_FWE_B_24   AF23
R26   | 243   IO_L15P_SM15P_15   R26
E13   | 244   IO_L15P_SM7P_35   E13
AL33   | 245   IO_L16N_12   AL33
AG32   | 246   IO_L16N_13   AG32
W32   | 247   IO_L16N_14   W32
J34   | 248   IO_L16N_16   J34
AJ21   | 249   IO_L16N_22   AJ21
AL25   | 250   IO_L16N_23   AL25
K22   | 251   IO_L16N_26   K22
AE17   | 252   IO_L16N_32   AE17
AH12   | 253   IO_L16N_33   AH12
F15   | 254   IO_L16N_36   F15
AF10   | 255   IO_L16N_A20_34   AF10
AB23   | 256   IO_L16N_CSO_B_24   AB23
L34   | 257   IO_L16N_VRP_15   L34
F29   | 258   IO_L16N_VRP_25   F29
L11   | 259   IO_L16N_VRP_35   L11
AM33   | 260   IO_L16P_12   AM33
AG33   | 261   IO_L16P_13   AG33
W31   | 262   IO_L16P_14   W31
K33   | 263   IO_L16P_16   K33
AK21   | 264   IO_L16P_22   AK21
AM25   | 265   IO_L16P_23   AM25
K21   | 266   IO_L16P_26   K21
AD17   | 267   IO_L16P_32   AD17
AG12   | 268   IO_L16P_33   AG12
G15   | 269   IO_L16P_36   G15
AF9   | 270   IO_L16P_A21_34   AF9
AA23   | 271   IO_L16P_RS0_24   AA23
K34   | 272   IO_L16P_VRN_15   K34
E29   | 273   IO_L16P_VRN_25   E29
K11   | 274   IO_L16P_VRN_35   K11
AM32   | 275   IO_L17N_12   AM32
AB26   | 276   IO_L17N_13   AB26
Y27   | 277   IO_L17N_14   Y27
N30   | 278   IO_L17N_15   N30
H32   | 279   IO_L17N_16   H32
AN22   | 280   IO_L17N_22   AN22
AN24   | 281   IO_L17N_23   AN24
D30   | 282   IO_L17N_25   D30
C18   | 283   IO_L17N_26   C18
AK17   | 284   IO_L17N_32   AK17
AL13   | 285   IO_L17N_33   AL13
E12   | 286   IO_L17N_35   E12
M15   | 287   IO_L17N_36   M15
AP9   | 288   IO_L17N_A18_34   AP9
AE22   | 289   IO_L17N_VRP_24   AE22
AN32   | 290   IO_L17P_12   AN32
AA26   | 291   IO_L17P_13   AA26
Y28   | 292   IO_L17P_14   Y28
M30   | 293   IO_L17P_15   M30
G32   | 294   IO_L17P_16   G32
AM22   | 295   IO_L17P_22   AM22
AN25   | 296   IO_L17P_23   AN25
C30   | 297   IO_L17P_25   C30
B18   | 298   IO_L17P_26   B18
AK18   | 299   IO_L17P_32   AK18
AK13   | 300   IO_L17P_33   AK13
D12   | 301   IO_L17P_35   D12
M16   | 302   IO_L17P_36   M16
AN9   | 303   IO_L17P_A19_34   AN9
AE23   | 304   IO_L17P_VRN_24   AE23
AP33   | 305   IO_L18N_12   AP33
AF31   | 306   IO_L18N_13   AF31
V25   | 307   IO_L18N_14   V25
P34   | 308   IO_L18N_15   P34
L26   | 309   IO_L18N_16   L26
AG21   | 310   IO_L18N_22   AG21
AL24   | 311   IO_L18N_23   AL24
AC24   | 312   IO_L18N_24   AC24
L21   | 313   IO_L18N_26   L21
AF18   | 314   IO_L18N_32   AF18
AH14   | 315   IO_L18N_33   AH14
J15   | 316   IO_L18N_36   J15
AH8   | 317   IO_L18N_A16_34   AH8
H29   | 318   IO_L18N_GC_25   H29
K12   | 319   IO_L18N_GC_35   K12
AP32   | 320   IO_L18P_12   AP32
AG31   | 321   IO_L18P_13   AG31
W25   | 322   IO_L18P_14   W25
N34   | 323   IO_L18P_15   N34
L25   | 324   IO_L18P_16   L25
AG20   | 325   IO_L18P_22   AG20
AK23   | 326   IO_L18P_23   AK23
AC23   | 327   IO_L18P_24   AC23
L20   | 328   IO_L18P_26   L20
AE18   | 329   IO_L18P_32   AE18
AH13   | 330   IO_L18P_33   AH13
H15   | 331   IO_L18P_36   H15
AG8   | 332   IO_L18P_A17_34   AG8
H28   | 333   IO_L18P_GC_25   H28
K13   | 334   IO_L18P_GC_35   K13
AM31   | 335   IO_L19N_12   AM31
AC25   | 336   IO_L19N_13   AC25
W26   | 337   IO_L19N_14   W26
R29   | 338   IO_L19N_15   R29
J32   | 339   IO_L19N_16   J32
AN23   | 340   IO_L19N_22   AN23
AP24   | 341   IO_L19N_23   AP24
AD22   | 342   IO_L19N_24   AD22
D22   | 343   IO_L19N_26   D22
AK16   | 344   IO_L19N_32   AK16
AN14   | 345   IO_L19N_33   AN14
C15   | 346   IO_L19N_36   C15
A31   | 347   IO_L19N_GC_25   A31
E11   | 348   IO_L19N_GC_35   E11
AP10   | 349   IO_L19N_VRP_34   AP10
AL30   | 350   IO_L19P_12   AL30
AB25   | 351   IO_L19P_13   AB25
W27   | 352   IO_L19P_14   W27
P29   | 353   IO_L19P_15   P29
J31   | 354   IO_L19P_16   J31
AP22   | 355   IO_L19P_22   AP22
AP25   | 356   IO_L19P_23   AP25
AC22   | 357   IO_L19P_24   AC22
C22   | 358   IO_L19P_26   C22
AL16   | 359   IO_L19P_32   AL16
AP14   | 360   IO_L19P_33   AP14
D15   | 361   IO_L19P_36   D15
B31   | 362   IO_L19P_GC_25   B31
D11   | 363   IO_L19P_GC_35   D11
AN10   | 364   IO_L19P_VRN_34   AN10
AD27   | 365   IO_L1N_12   AD27
AA31   | 366   IO_L1N_13   AA31
T29   | 367   IO_L1N_14   T29
M25   | 368   IO_L1N_15   M25
J27   | 369   IO_L1N_16   J27
AL18   | 370   IO_L1N_22   AL18
AM30   | 371   IO_L1N_23   AM30
C25   | 372   IO_L1N_25   C25
A24   | 373   IO_L1N_26   A24
AJ14   | 374   IO_L1N_32   AJ14
AK11   | 375   IO_L1N_33   AK11
C14   | 376   IO_L1N_35   C14
D17   | 377   IO_L1N_36   D17
K23   | 378   IO_L1N_GC_24   K23
B10   | 379   IO_L1N_GC_34   B10
AE27   | 380   IO_L1P_12   AE27
AA30   | 381   IO_L1P_13   AA30
T28   | 382   IO_L1P_14   T28
N25   | 383   IO_L1P_15   N25
J26   | 384   IO_L1P_16   J26
AM18   | 385   IO_L1P_22   AM18
AN30   | 386   IO_L1P_23   AN30
C24   | 387   IO_L1P_25   C24
A23   | 388   IO_L1P_26   A23
AK14   | 389   IO_L1P_32   AK14
AJ11   | 390   IO_L1P_33   AJ11
D14   | 391   IO_L1P_35   D14
E18   | 392   IO_L1P_36   E18
K24   | 393   IO_L1P_GC_24   K24
A10   | 394   IO_L1P_GC_34   A10
AH32   | 395   IO_L2N_12   AH32
AC34   | 396   IO_L2N_13   AC34
R34   | 397   IO_L2N_14   R34
E33   | 398   IO_L2N_16   E33
AH22   | 399   IO_L2N_22   AH22
AG26   | 400   IO_L2N_23   AG26
F26   | 401   IO_L2N_25   F26
G22   | 402   IO_L2N_26   G22
AH15   | 403   IO_L2N_32   AH15
AC14   | 404   IO_L2N_33   AC14
K17   | 405   IO_L2N_36   K17
F10   | 406   IO_L2N_A14_D30_34   F10
L24   | 407   IO_L2N_D14_24   L24
F11   | 408   IO_L2N_SM0N_35   F11
K31   | 409   IO_L2N_SM8N_15   K31
AH33   | 410   IO_L2P_12   AH33
AD34   | 411   IO_L2P_13   AD34
R33   | 412   IO_L2P_14   R33
E32   | 413   IO_L2P_16   E32
AG22   | 414   IO_L2P_22   AG22
AG25   | 415   IO_L2P_23   AG25
E26   | 416   IO_L2P_25   E26
G21   | 417   IO_L2P_26   G21
AJ15   | 418   IO_L2P_32   AJ15
AD14   | 419   IO_L2P_33   AD14
K18   | 420   IO_L2P_36   K18
F9   | 421   IO_L2P_A15_D31_34   F9
M23   | 422   IO_L2P_D15_24   M23
G11   | 423   IO_L2P_SM0P_35   G11
K32   | 424   IO_L2P_SM8P_15   K32
AE29   | 425   IO_L3N_12   AE29
AB31   | 426   IO_L3N_13   AB31
T31   | 427   IO_L3N_14   T31
G30   | 428   IO_L3N_16   G30
AN18   | 429   IO_L3N_22   AN18
AP31   | 430   IO_L3N_23   AP31
A25   | 431   IO_L3N_25   A25
C23   | 432   IO_L3N_26   C23
AL14   | 433   IO_L3N_32   AL14
AJ12   | 434   IO_L3N_33   AJ12
G17   | 435   IO_L3N_36   G17
D10   | 436   IO_L3N_A12_D28_34   D10
F23   | 437   IO_L3N_D12_24   F23
A14   | 438   IO_L3N_SM1N_35   A14
M27   | 439   IO_L3N_SM9N_15   M27
AE28   | 440   IO_L3P_12   AE28
AB30   | 441   IO_L3P_13   AB30
T30   | 442   IO_L3P_14   T30
F30   | 443   IO_L3P_16   F30
AP19   | 444   IO_L3P_22   AP19
AP30   | 445   IO_L3P_23   AP30
B25   | 446   IO_L3P_25   B25
B23   | 447   IO_L3P_26   B23
AL15   | 448   IO_L3P_32   AL15
AK12   | 449   IO_L3P_33   AK12
H17   | 450   IO_L3P_36   H17
C10   | 451   IO_L3P_A13_D29_34   C10
F24   | 452   IO_L3P_D13_24   F24
A13   | 453   IO_L3P_SM1P_35   A13
M26   | 454   IO_L3P_SM9P_15   M26
AH34   | 455   IO_L4N_VREF_12   AH34
AB33   | 456   IO_L4N_VREF_13   AB33
T34   | 457   IO_L4N_VREF_14   T34
P30   | 458   IO_L4N_VREF_15   P30
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[Model Data]
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[End Model Data]
[End Package Model]
| Models and submodels in the file (2): LVCMOS25_F_12 (I/O), LVCMOS25_S_12 (I/O)
